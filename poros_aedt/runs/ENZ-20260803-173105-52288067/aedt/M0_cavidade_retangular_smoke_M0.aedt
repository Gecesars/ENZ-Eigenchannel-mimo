# Ansys Electronics Desktop project, version 2024.2
materials:
  vacuum: permittivity=1

design HFSS_ENZ_M0_cavidade_retangular_smoke_M0 (HFSS, Eigenmode, model units mm)
variables:
  cavidade_comprimento = 20mm
  cavidade_largura = 14mm
  cavidade_altura = 7.7143mm
geometry:
  Cavity_Air [vacuum] = box(corner=(0mm, 0mm, 0mm), size=(cavidade_comprimento, cavidade_largura, cavidade_altura))
boundaries and excitations:
  PEC_Cavity: Perfect E Faces=Cavity_Air.face(all 6)
setups:
  Setup_Eigen_18_32: HfssEigen MinimumFrequency=18GHz NumModes=4 MaxDeltaFreq=0.5 ConvergeOnRealFreq=false MaximumPasses=6 MinimumPasses=1 MinimumConvergedPasses=2 PercentRefinement=20 BasisOrder=1
source amplitudes:
  #-10:1: 1 0deg
  #-10:2, #-10:3, #-10:4: 0 0deg
