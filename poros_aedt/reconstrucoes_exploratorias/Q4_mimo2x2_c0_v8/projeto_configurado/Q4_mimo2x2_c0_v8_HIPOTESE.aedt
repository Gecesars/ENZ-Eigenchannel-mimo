# Ansys Electronics Desktop project, version 2024.2
materials:
  vacuum: permittivity=1
  pec: conductivity=1e+30
  FR4_epoxy: permittivity=4.4 dielectric_loss_tangent=0.02
  air: permittivity=1.0006 permeability=1.0000004
surface materials:
  Steel-oxidised-surface

design HFSS_ENZ_Q4_mimo2x2_c0_v8 (HFSS, HFSS Modal Network, model units mm)
variables:
  frequencia_adaptativa = 25.87GHz
  frequencia_sweep_inicio = 25GHz
  frequencia_sweep_fim = 27GHz
  cavidade_area_plana = 108mm2
  cavidade_comprimento_interno_exploratorio = 18mm
  cavidade_largura_interna_exploratoria = 6mm
  corpo_comprimento_externo = 36mm
  corpo_largura_externa_exploratoria = 9mm
  corpo_altura_externa = 11.11mm
  altura_interna_wr28 = 7.11mm
  largura_interna_wr28 = 3.56mm
  espessura_parede_lateral = 1mm
  espessura_tampa = 1mm
  espessura_fundo_exploratoria = 3mm
  flange_largura = 22.5mm
  flange_comprimento_exploratorio = 4mm
  comprimento_total_eixo_y = 27mm
  plano_porta_y = -18mm
  chanfro = 3mm  # tune 1.5mm..4.5mm
  degrau_largura = 9mm  # tune 4.5mm..13.5mm
  degrau_altura = 1mm  # tune 0.5mm..1.5mm
  ranhura_comprimento = 5.66mm
  ranhura_largura = 0.8mm
  ranhura_passo_exploratorio = 4mm
  fr4_dimensao_x = 3mm
  fr4_dimensao_y = 1.65mm
  fr4_epsilon_r_exploratorio = 4.4
  fr4_tan_delta_exploratorio = 0.02
  pino_diametro = 1mm
  pino_offset_x_exploratorio = 2mm
  pino_offset_y_exploratorio = 1.325mm
  parafuso_diametro_exploratorio = 2mm
  q4_frequency = 25.87GHz
  q4_wg_a_z = 7.11mm
  q4_wg_b_x = 3.56mm
  q4_pair_spacing = 42mm
  q4_interpair_spacing = 96mm
  q4_lambda_g = 19.995624mm
  q4_branch_length = 19.995624mm
  q4_junction_length = 4.9989061mm
  q4_input_length = 19.995624mm
  q4_external_port_y = -62.990155mm
geometry:
  Housing_Cavity_RAD_A1 [pec] = polyline(z=0mm, xy: (-corpo_comprimento_externo/2, chanfro) (-corpo_comprimento_externo/2+chanfro, 0mm) (corpo_comprimento_externo/2-chanfro, 0mm) (corpo_comprimento_externo/2, chanfro) (corpo_comprimento_externo/2, corpo_largura_externa_exploratoria-chanfro) (corpo_comprimento_externo/2-chanfro, corpo_largura_externa_exploratoria) (degrau_largura/2, corpo_largura_externa_exploratoria) (degrau_largura/2, corpo_largura_externa_exploratoria+degrau_altura) (-degrau_largura/2, corpo_largura_externa_exploratoria+degrau_altura) (-degrau_largura/2, corpo_largura_externa_exploratoria) (-corpo_comprimento_externo/2+chanfro, corpo_largura_externa_exploratoria) (-corpo_comprimento_externo/2, corpo_largura_externa_exploratoria-chanfro) (-corpo_comprimento_externo/2, chanfro), closed, covered)
  Housing_Cavity_RAD_A1.sweep_along_vector((0mm, 0mm, corpo_altura_externa))
  Housing_Feed = box(corner=(-2.78mm, plano_porta_y, 0mm), size=(5.56mm, 19.5mm, corpo_altura_externa))
  Housing_Flange = box(corner=(-11.25mm, plano_porta_y, 0mm), size=(flange_largura, flange_comprimento_exploratorio, corpo_altura_externa))
  Cavity_Air_RAD_A1 [vacuum] = box(corner=(-9mm, 1.5mm, espessura_fundo_exploratoria), size=(cavidade_comprimento_interno_exploratorio, cavidade_largura_interna_exploratoria, altura_interna_wr28))
  Feed_Air = box(corner=(-1.78mm, plano_porta_y, espessura_fundo_exploratoria), size=(largura_interna_wr28, 19.5mm, altura_interna_wr28))
  Slot_Air_1 = box(corner=(-2*ranhura_passo_exploratorio-ranhura_largura/2, 1.67mm, 10.11mm), size=(ranhura_largura, ranhura_comprimento, 1.2mm))
  Slot_Air_2 = box(corner=(-ranhura_passo_exploratorio-ranhura_largura/2, 1.67mm, 10.11mm), size=(ranhura_largura, ranhura_comprimento, 1.2mm))
  Slot_Air_3 = box(corner=(-ranhura_largura/2, 1.67mm, 10.11mm), size=(ranhura_largura, ranhura_comprimento, 1.2mm))
  Slot_Air_4 = box(corner=(ranhura_passo_exploratorio-ranhura_largura/2, 1.67mm, 10.11mm), size=(ranhura_largura, ranhura_comprimento, 1.2mm))
  Slot_Air_5 = box(corner=(2*ranhura_passo_exploratorio-ranhura_largura/2, 1.67mm, 10.11mm), size=(ranhura_largura, ranhura_comprimento, 1.2mm))
  FR4_Slab_RAD_A1 [FR4_epoxy] = box(corner=(-1.5mm, 3.675mm, espessura_fundo_exploratoria), size=(fr4_dimensao_x, fr4_dimensao_y, altura_interna_wr28))
  Rod_PEC_NW_RAD_A1 [pec] = cylinder(axis=Z, base_centre=(-pino_offset_x_exploratorio, 4.5mm-pino_offset_y_exploratorio, espessura_fundo_exploratoria), radius=0.5mm, height=altura_interna_wr28)
  Rod_PEC_NE_RAD_A1 [pec] = cylinder(axis=Z, base_centre=(pino_offset_x_exploratorio, 4.5mm-pino_offset_y_exploratorio, espessura_fundo_exploratoria), radius=0.5mm, height=altura_interna_wr28)
  Rod_PEC_SW_RAD_A1 [pec] = cylinder(axis=Z, base_centre=(-pino_offset_x_exploratorio, 4.5mm+pino_offset_y_exploratorio, espessura_fundo_exploratoria), radius=0.5mm, height=altura_interna_wr28)
  Rod_PEC_SE_RAD_A1 [pec] = cylinder(axis=Z, base_centre=(pino_offset_x_exploratorio, 4.5mm+pino_offset_y_exploratorio, espessura_fundo_exploratoria), radius=0.5mm, height=altura_interna_wr28)
  MountHole_L_RAD_A1 [vacuum] = cylinder(axis=Z, base_centre=(-8mm, -16mm, -0.1mm), radius=1mm, height=11.31mm)
  MountHole_R_RAD_A1 [vacuum] = cylinder(axis=Z, base_centre=(8mm, -16mm, -0.1mm), radius=1mm, height=11.31mm)
  Housing_Cavity_RAD_A1.unite(Housing_Feed, Housing_Flange)
  Cavity_Air_1 = Cavity_Air_RAD_A1.copy()
  Feed_Air_1 = Feed_Air.copy()
  Housing_Cavity_RAD_A1.subtract(Cavity_Air_1, Feed_Air_1)
  Slot_Air_1_1 = Slot_Air_1.copy()
  Slot_Air_2_1 = Slot_Air_2.copy()
  Slot_Air_3_1 = Slot_Air_3.copy()
  Slot_Air_4_1 = Slot_Air_4.copy()
  Slot_Air_5_1 = Slot_Air_5.copy()
  Housing_Cavity_RAD_A1.subtract(Slot_Air_1_1, Slot_Air_2_1, Slot_Air_3_1, Slot_Air_4_1, Slot_Air_5_1)
  MountHole_L_1 = MountHole_L_RAD_A1.copy()
  MountHole_R_1 = MountHole_R_RAD_A1.copy()
  Housing_Cavity_RAD_A1.subtract(MountHole_L_1, MountHole_R_1)
  Cavity_Air_RAD_A1.unite(Feed_Air, Slot_Air_1..Slot_Air_5)
  FR4_Slab_1 = FR4_Slab_RAD_A1.copy()
  Rod_PEC_NW_1 = Rod_PEC_NW_RAD_A1.copy()
  Rod_PEC_NE_1 = Rod_PEC_NE_RAD_A1.copy()
  Rod_PEC_SW_1 = Rod_PEC_SW_RAD_A1.copy()
  Rod_PEC_SE_1 = Rod_PEC_SE_RAD_A1.copy()
  Cavity_Air_RAD_A1.subtract(FR4_Slab_1, Rod_PEC_NW_1, Rod_PEC_NE_1, Rod_PEC_SW_1, Rod_PEC_SE_1)
  [Cavity_Air_RAD_A1, FR4_Slab_RAD_A1, Housing_Cavity_RAD_A1, MountHole_L_RAD_A1, MountHole_R_RAD_A1, Rod_PEC_NE_RAD_A1, Rod_PEC_NW_RAD_A1, Rod_PEC_SE_RAD_A1, Rod_PEC_SW_RAD_A1].move(-69mm, 0mm, 0mm)
  Cavity_Air_RAD_A2 [vacuum] = Cavity_Air_RAD_A1.duplicate_along_line(step=(42mm, 0mm, 0mm), total=2)
  FR4_Slab_RAD_A2 [FR4_epoxy] = FR4_Slab_RAD_A1.duplicate_along_line(step=(42mm, 0mm, 0mm), total=2)
  Housing_Cavity_RAD_A2 [pec] = Housing_Cavity_RAD_A1.duplicate_along_line(step=(42mm, 0mm, 0mm), total=2)
  MountHole_L_RAD_A2 [vacuum] = MountHole_L_RAD_A1.duplicate_along_line(step=(42mm, 0mm, 0mm), total=2)
  MountHole_R_RAD_A2 [vacuum] = MountHole_R_RAD_A1.duplicate_along_line(step=(42mm, 0mm, 0mm), total=2)
  Rod_PEC_NE_RAD_A2 [pec] = Rod_PEC_NE_RAD_A1.duplicate_along_line(step=(42mm, 0mm, 0mm), total=2)
  Rod_PEC_NW_RAD_A2 [pec] = Rod_PEC_NW_RAD_A1.duplicate_along_line(step=(42mm, 0mm, 0mm), total=2)
  Rod_PEC_SE_RAD_A2 [pec] = Rod_PEC_SE_RAD_A1.duplicate_along_line(step=(42mm, 0mm, 0mm), total=2)
  Rod_PEC_SW_RAD_A2 [pec] = Rod_PEC_SW_RAD_A1.duplicate_along_line(step=(42mm, 0mm, 0mm), total=2)
  Cavity_Air_RAD_B1 [vacuum] = Cavity_Air_RAD_A1.duplicate_along_line(step=(96mm, 0mm, 0mm), total=2)
  FR4_Slab_RAD_B1 [FR4_epoxy] = FR4_Slab_RAD_A1.duplicate_along_line(step=(96mm, 0mm, 0mm), total=2)
  Housing_Cavity_RAD_B1 [pec] = Housing_Cavity_RAD_A1.duplicate_along_line(step=(96mm, 0mm, 0mm), total=2)
  MountHole_L_RAD_B1 [vacuum] = MountHole_L_RAD_A1.duplicate_along_line(step=(96mm, 0mm, 0mm), total=2)
  MountHole_R_RAD_B1 [vacuum] = MountHole_R_RAD_A1.duplicate_along_line(step=(96mm, 0mm, 0mm), total=2)
  Rod_PEC_NE_RAD_B1 [pec] = Rod_PEC_NE_RAD_A1.duplicate_along_line(step=(96mm, 0mm, 0mm), total=2)
  Rod_PEC_NW_RAD_B1 [pec] = Rod_PEC_NW_RAD_A1.duplicate_along_line(step=(96mm, 0mm, 0mm), total=2)
  Rod_PEC_SE_RAD_B1 [pec] = Rod_PEC_SE_RAD_A1.duplicate_along_line(step=(96mm, 0mm, 0mm), total=2)
  Rod_PEC_SW_RAD_B1 [pec] = Rod_PEC_SW_RAD_A1.duplicate_along_line(step=(96mm, 0mm, 0mm), total=2)
  Cavity_Air_RAD_B2 [vacuum] = Cavity_Air_RAD_A1.duplicate_along_line(step=(138mm, 0mm, 0mm), total=2)
  FR4_Slab_RAD_B2 [FR4_epoxy] = FR4_Slab_RAD_A1.duplicate_along_line(step=(138mm, 0mm, 0mm), total=2)
  Housing_Cavity_RAD_B2 [pec] = Housing_Cavity_RAD_A1.duplicate_along_line(step=(138mm, 0mm, 0mm), total=2)
  MountHole_L_RAD_B2 [vacuum] = MountHole_L_RAD_A1.duplicate_along_line(step=(138mm, 0mm, 0mm), total=2)
  MountHole_R_RAD_B2 [vacuum] = MountHole_R_RAD_A1.duplicate_along_line(step=(138mm, 0mm, 0mm), total=2)
  Rod_PEC_NE_RAD_B2 [pec] = Rod_PEC_NE_RAD_A1.duplicate_along_line(step=(138mm, 0mm, 0mm), total=2)
  Rod_PEC_NW_RAD_B2 [pec] = Rod_PEC_NW_RAD_A1.duplicate_along_line(step=(138mm, 0mm, 0mm), total=2)
  Rod_PEC_SE_RAD_B2 [pec] = Rod_PEC_SE_RAD_A1.duplicate_along_line(step=(138mm, 0mm, 0mm), total=2)
  Rod_PEC_SW_RAD_B2 [pec] = Rod_PEC_SW_RAD_A1.duplicate_along_line(step=(138mm, 0mm, 0mm), total=2)
  WG_A_Housing_PEC [pec] = box(corner=(-71.78mm, -62.990155mm, 0mm), size=(47.56mm, 44.990155mm, 11.11mm))
  WG_A_Air [vacuum] = imported_body()
  WG_A_Air_1 = WG_A_Air.copy()
  WG_A_Housing_PEC.subtract(WG_A_Air_1)
  P1_WG_A_Sheet = rectangle(corner=(-49.78mm, -62.990155mm, 3mm), z_size=7.11mm, x_size=3.56mm)
  WG_B_Housing_PEC [pec] = box(corner=(24.22mm, -62.990155mm, 0mm), size=(47.56mm, 44.990155mm, 11.11mm))
  WG_B_Air [vacuum] = imported_body()
  WG_B_Air_1 = WG_B_Air.copy()
  WG_B_Housing_PEC.subtract(WG_B_Air_1)
  P2_WG_B_Sheet = rectangle(corner=(46.22mm, -62.990155mm, 3mm), z_size=7.11mm, x_size=3.56mm)
  Open_Region_Q4 [air] = box(corner=(-105mm, -62.990155mm, -13.792mm), size=(210mm, 95.390155mm, 38.794mm))
  coordinate_system CS_RAD_A1 = origin=(-69mm, 0mm, 0mm) x=(1mm, 0mm, 0mm) y=(0mm, 1mm, 0mm)
  coordinate_system Cut_Q4_YZ_RAD_A1 = origin=(-69mm, 0mm, 0mm) x=(1mm, 0mm, 0mm) y=(0mm, 1mm, 0mm)
  coordinate_system CS_RAD_A2 = origin=(-27mm, 0mm, 0mm) x=(1mm, 0mm, 0mm) y=(0mm, 1mm, 0mm)
  coordinate_system Cut_Q4_YZ_RAD_A2 = origin=(-27mm, 0mm, 0mm) x=(1mm, 0mm, 0mm) y=(0mm, 1mm, 0mm)
  coordinate_system CS_RAD_B1 = origin=(27mm, 0mm, 0mm) x=(1mm, 0mm, 0mm) y=(0mm, 1mm, 0mm)
  coordinate_system Cut_Q4_YZ_RAD_B1 = origin=(27mm, 0mm, 0mm) x=(1mm, 0mm, 0mm) y=(0mm, 1mm, 0mm)
  coordinate_system CS_RAD_B2 = origin=(69mm, 0mm, 0mm) x=(1mm, 0mm, 0mm) y=(0mm, 1mm, 0mm)
  coordinate_system Cut_Q4_YZ_RAD_B2 = origin=(69mm, 0mm, 0mm) x=(1mm, 0mm, 0mm) y=(0mm, 1mm, 0mm)
  coordinate_system CS_WG_A = origin=(-48mm, -62.990155mm, 0mm) x=(1mm, 0mm, 0mm) y=(0mm, 1mm, 0mm)
  coordinate_system Cut_Q4_YZ_WG_A = origin=(-48mm, 0mm, 0mm) x=(1mm, 0mm, 0mm) y=(0mm, 1mm, 0mm)
  coordinate_system CS_WG_B = origin=(48mm, -62.990155mm, 0mm) x=(1mm, 0mm, 0mm) y=(0mm, 1mm, 0mm)
  coordinate_system Cut_Q4_YZ_WG_B = origin=(48mm, 0mm, 0mm) x=(1mm, 0mm, 0mm) y=(0mm, 1mm, 0mm)
  coordinate_system Cut_Q4_XY_MidHeight = origin=(0mm, 0mm, 6.555mm) x=(1mm, 0mm, 0mm) y=(0mm, 1mm, 0mm)
  coordinate_system Cut_Q4_XZ_ArrayCenter = origin=(0mm, 4.5mm, 0mm) x=(1mm, 0mm, 0mm) y=(0mm, 1mm, 0mm)
  coordinate_system Cut_Q4_XZ_Feed = origin=(0mm, -40.495077mm, 0mm) x=(1mm, 0mm, 0mm) y=(0mm, 1mm, 0mm)
boundaries and excitations:
  Radiation_Q4_5Faces: Radiation Faces=Open_Region_Q4.face(+z, -x, +y, -z, +x)
  P1_WG_A: Wave Port Objects=P1_WG_A_Sheet WavePortType=Modal NumModes=1 Modes{Mode1{IntLine{(-48, -62.990155, 3) -> (-48, -62.990155, 10.11)} CharImp=Zpi RenormImp=50ohm}}
  P2_WG_B: Wave Port Objects=P2_WG_B_Sheet WavePortType=Modal NumModes=1 Modes{Mode1{IntLine{(48, -62.990155, 3) -> (48, -62.990155, 10.11)} CharImp=Zpi RenormImp=50ohm}}
mesh:
  Mesh_Q4_WG_Cavity_Air_1p2mm: LengthBased RefineInside Objects=[Cavity_Air_RAD_A1, Cavity_Air_RAD_A2, Cavity_Air_RAD_B1, Cavity_Air_RAD_B2, WG_A_Air, WG_B_Air] NumMaxElem=1000000 MaxLength=1.2mm
  Mesh_Q4_FR4_0p35mm: LengthBased RefineInside Objects=[FR4_Slab_RAD_A1, FR4_Slab_RAD_A2, FR4_Slab_RAD_B1, FR4_Slab_RAD_B2] NumMaxElem=500000 MaxLength=0.35mm
setups:
  Setup_Q4_MIMO2X2: HfssDriven Frequency=25.87GHz MaxDeltaS=0.02 MaximumPasses=12 MinimumPasses=2 MinimumConvergedPasses=2 PercentRefinement=20 BasisOrder=1 PortAccuracy=2 DrivenSolverType="Direct Solver"
    sweep Sweep_Q4_25_27GHz: 25GHz to 27GHz, 81 points; Type=Interpolating InterpTolerance=0.5 InterpMaxSolns=250 InterpUsePortImped=false PassivityErrorTolerance=0.0001
source amplitudes:
  P1_WG_A:1, P2_WG_B:1: 0.5W 0deg
radiation setups:
  FF_Q4_3D: Infinite Sphere Theta=0deg..180deg step 2deg Phi=0deg..360deg step 2deg
field plots:
  EMag_YZ_RAD_A1_25p87: EMag_YZ_RAD_A1_25p87 over a plane on Setup_Q4_MIMO2X2 : LastAdaptive at Freq=25.87GHz Phase=0deg
  EMag_YZ_RAD_A2_25p87: EMag_YZ_RAD_A2_25p87 over a plane on Setup_Q4_MIMO2X2 : LastAdaptive at Freq=25.87GHz Phase=0deg
  EMag_YZ_RAD_B1_25p87: EMag_YZ_RAD_B1_25p87 over a plane on Setup_Q4_MIMO2X2 : LastAdaptive at Freq=25.87GHz Phase=0deg
  EMag_YZ_RAD_B2_25p87: EMag_YZ_RAD_B2_25p87 over a plane on Setup_Q4_MIMO2X2 : LastAdaptive at Freq=25.87GHz Phase=0deg
  EMag_YZ_WG_A_25p87: EMag_YZ_WG_A_25p87 over a plane on Setup_Q4_MIMO2X2 : LastAdaptive at Freq=25.87GHz Phase=0deg
  EMag_YZ_WG_B_25p87: EMag_YZ_WG_B_25p87 over a plane on Setup_Q4_MIMO2X2 : LastAdaptive at Freq=25.87GHz Phase=0deg
  EMag_XY_MidHeight_25p87: EMag_XY_MidHeight_25p87 over a plane on Setup_Q4_MIMO2X2 : LastAdaptive at Freq=25.87GHz Phase=0deg
  EMag_XZ_ArrayCenter_25p87: EMag_XZ_ArrayCenter_25p87 over a plane on Setup_Q4_MIMO2X2 : LastAdaptive at Freq=25.87GHz Phase=0deg
  EMag_XZ_Feed_25p87: EMag_XZ_Feed_25p87 over a plane on Setup_Q4_MIMO2X2 : LastAdaptive at Freq=25.87GHz Phase=0deg
reports:
  S_Q4_2Port_25_27GHz: dB(S(P1_WG_A,P1_WG_A)), dB(S(P1_WG_A,P2_WG_B)), dB(S(P2_WG_B,P1_WG_A)), dB(S(P2_WG_B,P2_WG_B)) vs Freq on Setup_Q4_MIMO2X2 : Sweep_Q4_25_27GHz [frequencia_adaptativa=25.87GHz frequencia_sweep_inicio=25GHz frequencia_sweep_fim=27GHz cavidade_area_plana=0.000108 cavidade_comprimento_interno_exploratorio=18mm cavidade_largura_interna_exploratoria=6mm corpo_comprimento_externo=36mm corpo_largura_externa_exploratoria=9mm corpo_altura_externa=11.11mm altura_interna_wr28=7.11mm largura_interna_wr28=3.56mm espessura_parede_lateral=1mm espessura_tampa=1mm espessura_fundo_exploratoria=3mm flange_largura=22.5mm flange_comprimento_exploratorio=4mm comprimento_total_eixo_y=27mm plano_porta_y=-18mm chanfro=3mm degrau_largura=9mm degrau_altura=1mm ranhura_comprimento=5.66mm ranhura_largura=0.8mm ranhura_passo_exploratorio=4mm fr4_dimensao_x=3mm fr4_dimensao_y=1.65mm fr4_epsilon_r_exploratorio=4.4 fr4_tan_delta_exploratorio=0.02 pino_diametro=1mm pino_offset_x_exploratorio=2mm pino_offset_y_exploratorio=1.325mm parafuso_diametro_exploratorio=2mm q4_frequency=25.87GHz q4_wg_a_z=7.11mm q4_wg_b_x=3.56mm q4_pair_spacing=42mm q4_interpair_spacing=96mm q4_lambda_g=19.9956mm q4_branch_length=19.9956mm q4_junction_length=4.99891mm q4_input_length=19.9956mm q4_external_port_y=-62.9902mm]
  Q4_EPlane_RealizedGain_25p87: dB(RealizedGainTheta), dB(RealizedGainPhi) vs Theta on Setup_Q4_MIMO2X2 : LastAdaptive, FF_Q4_3D [Phi=0deg Freq=25.87GHz]
  Q4_HPlane_RealizedGain_25p87: dB(RealizedGainTheta), dB(RealizedGainPhi) vs Theta on Setup_Q4_MIMO2X2 : LastAdaptive, FF_Q4_3D [Phi=90deg Freq=25.87GHz]
  Q4_Gain3D_25p87: dB(RealizedGainTheta), dB(RealizedGainPhi) vs Phi, Theta on Setup_Q4_MIMO2X2 : LastAdaptive, FF_Q4_3D [Freq=25.87GHz]
